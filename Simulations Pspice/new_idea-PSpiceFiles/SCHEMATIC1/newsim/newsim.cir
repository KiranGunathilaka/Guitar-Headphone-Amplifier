** Profile: "SCHEMATIC1-newsim"  [ c:\users\nuwan\documents\pspice\new_idea-pspicefiles\schematic1\newsim.sim ]

** Creating circuit file "newsim.cir"
** WARNING: THIS AUTOMATICALLY GENERATED FILE MAY BE OVERWRITTEN BY SUBSEQUENT SIMULATIONS

*Libraries:
* Profile Libraries :
* Local Libraries :
* From [PSPICE NETLIST] section of E:\cdssetup\OrCAD_PSpice\23.1.0\PSpice.ini file:
.lib "nom.lib"

*Analysis directives:
.TRAN  0 5ms  0 0.00001
.OPTIONS ADVCONV
.PROBE64 V(alias(*)) I(alias(*)) W(alias(*)) D(alias(*)) NOISE(alias(*))
.INC "..\SCHEMATIC1.net"

.END
